.title KiCad schematic
.include "/app/share/kicad/symbols/Simulation_SPICE.sp"
XU1 Net-_C2-Pad2_ Net-_U1A--_ Net-_U1A-+_ GND +4.5V Net-_U1B--_ Net-_C8-Pad1_ +9V kicad_builtin_opamp_dual
C7 GND +9V 10u
R6 +9V +4.5V 47k
C6 GND +4.5V 10u
R5 +4.5V GND 47k
R7 Net-_C10-Pad2_ Net-_C3-Pad2_ 12k
C4 Net-_C4-Pad1_ Net-_C4-Pad2_ 100u
C5 Net-_C5-Pad1_ Net-_C4-Pad2_ 100u
tone-2 __tone-2
tone-1 __tone-1
R8 Net-_C8-Pad2_ output 3.3k
C8 Net-_C8-Pad1_ Net-_C8-Pad2_ 1u
R9 Net-_U1B--_ Net-_C4-Pad2_ 27k
R10 Net-_C4-Pad2_ Net-_C10-Pad1_ 8.2k
R3 Net-_C5-Pad1_ Net-_C8-Pad1_ 6.8k
C10 Net-_C10-Pad1_ Net-_C10-Pad2_ 100u
C9 GND output 100u
C3 Net-_C2-Pad2_ Net-_C3-Pad2_ 10u
R2 Net-_C3-Pad2_ Net-_C4-Pad1_ 12k
R11 +4.5V Net-_U1A-+_ 1Meg
C2 Net-_U1A--_ Net-_C2-Pad2_ 47u
R1 Net-_U1A--_ Net-_C2-Pad2_ 150k
R4 +4.5V Net-_U1A--_ 470k
C1 input Net-_U1A-+_ 50u
.end
